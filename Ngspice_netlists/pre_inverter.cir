.include TSMC_180nm.txt
.param LAMBDA=0.09u
.param width_P=20*LAMBDA
.param width_N=10*LAMBDA
.global gnd vdd
Vdd vdd gnd 1.8
Vin in gnd pulse 0 1.8 5ns 100ps 100ps 20ns 40ns

M1 out in gnd gnd CMOSN W={width_N} L={2*LAMBDA}
+ AS={5*width_N*LAMBDA} PS={10*LAMBDA+2*width_N} AD={5*width_N*LAMBDA} PD={10*LAMBDA+2*width_N}

M2 out in vdd vdd CMOSP W={width_P} L={2*LAMBDA}
+ AS={5*width_P*LAMBDA} PS={10*LAMBDA+2*width_P} AD={5*width_P*LAMBDA} PD={10*LAMBDA+2*width_P}

.tran 10p 200n

.control
run
set curplottitle = 'A.Pranav_2024102038'
set color0 = white
set color1=black
set linewidth=10
plot v(out) v(in)+2
.endc
